# Ansys Electronics Desktop project, version 2022.1
materials:
  vacuum: permittivity=1
  copper: permeability=0.999991 conductivity=58000000
  silicon: permittivity=11.9

design Netlist (Circuit Netlist)
options: Language=HSPICE IntegrationMethod=FFT
netlist:
.option PARHIER='local'
.option max_messages=1
.option num_threads=4

CQ0Pad1_G net_Q0Pad1 0 6.838999999999997e-14
CQ0Pad1_Q0Pad2 net_Q0Pad1 net_Q0Pad2 4.247999999999999e-14
CQ0Pad1_Q1Pad1 net_Q0Pad1 net_Q1Pad1 1.05e-15
CQ0Pad1_Q1Pad2 net_Q0Pad1 net_Q1Pad2 8.899999999999999e-16
CQ0Pad1_Q2Pad1 net_Q0Pad1 net_Q2Pad1 0.0
CQ0Pad1_Q2Pad2 net_Q0Pad1 net_Q2Pad2 0.0
CQ0Pad1_Q3Pad1 net_Q0Pad1 net_Q3Pad1 0.0
CQ0Pad1_Q3Pad2 net_Q0Pad1 net_Q3Pad2 0.0
CQ0Pad1_Q4Pad1 net_Q0Pad1 net_Q4Pad1 0.0
CQ0Pad1_Q4Pad2 net_Q0Pad1 net_Q4Pad2 0.0
CQ0Pad1_Q5Pad1 net_Q0Pad1 net_Q5Pad1 0.0
CQ0Pad1_Q5Pad2 net_Q0Pad1 net_Q5Pad2 0.0
CQ0Pad1_Q6Pad1 net_Q0Pad1 net_Q6Pad1 0.0
CQ0Pad1_Q6Pad2 net_Q0Pad1 net_Q6Pad2 0.0
CQ0Pad1_Q7Pad1 net_Q0Pad1 net_Q7Pad1 1e-17
CQ0Pad1_Q7Pad2 net_Q0Pad1 net_Q7Pad2 0.0
CQ0Pad1_R0Pad1 net_Q0Pad1 net_R0Pad1 0.0
CQ0Pad1_R0Pad2 net_Q0Pad1 net_R0Pad2 1.566e-14
CQ0Pad1_R1Pad1 net_Q0Pad1 net_R1Pad1 0.0
CQ0Pad1_R1Pad2 net_Q0Pad1 net_R1Pad2 6e-17
CQ0Pad1_R2Pad1 net_Q0Pad1 net_R2Pad1 -0.0
CQ0Pad1_R2Pad2 net_Q0Pad1 net_R2Pad2 0.0
CQ0Pad1_R3Pad1 net_Q0Pad1 net_R3Pad1 0.0
CQ0Pad1_R3Pad2 net_Q0Pad1 net_R3Pad2 0.0
CQ0Pad1_R4Pad1 net_Q0Pad1 net_R4Pad1 0.0
CQ0Pad1_R4Pad2 net_Q0Pad1 net_R4Pad2 0.0
CQ0Pad1_R5Pad1 net_Q0Pad1 net_R5Pad1 0.0
CQ0Pad1_R5Pad2 net_Q0Pad1 net_R5Pad2 0.0
CQ0Pad1_R6Pad1 net_Q0Pad1 net_R6Pad1 0.0
CQ0Pad1_R6Pad2 net_Q0Pad1 net_R6Pad2 0.0
CQ0Pad1_R7Pad1 net_Q0Pad1 net_R7Pad1 0.0
CQ0Pad1_R7Pad2 net_Q0Pad1 net_R7Pad2 0.0
CQ0Pad2_G net_Q0Pad2 0 7.288000000000003e-14
CQ0Pad2_Q1Pad1 net_Q0Pad2 net_Q1Pad1 9e-16
CQ0Pad2_Q1Pad2 net_Q0Pad2 net_Q1Pad2 1.11e-15
CQ0Pad2_Q2Pad1 net_Q0Pad2 net_Q2Pad1 0.0
CQ0Pad2_Q2Pad2 net_Q0Pad2 net_Q2Pad2 0.0
CQ0Pad2_Q3Pad1 net_Q0Pad2 net_Q3Pad1 0.0
CQ0Pad2_Q3Pad2 net_Q0Pad2 net_Q3Pad2 0.0
CQ0Pad2_Q4Pad1 net_Q0Pad2 net_Q4Pad1 0.0
CQ0Pad2_Q4Pad2 net_Q0Pad2 net_Q4Pad2 0.0
CQ0Pad2_Q5Pad1 net_Q0Pad2 net_Q5Pad1 1e-17
CQ0Pad2_Q5Pad2 net_Q0Pad2 net_Q5Pad2 0.0
CQ0Pad2_Q6Pad1 net_Q0Pad2 net_Q6Pad1 0.0
CQ0Pad2_Q6Pad2 net_Q0Pad2 net_Q6Pad2 0.0
CQ0Pad2_Q7Pad1 net_Q0Pad2 net_Q7Pad1 -0.0
CQ0Pad2_Q7Pad2 net_Q0Pad2 net_Q7Pad2 1e-17
CQ0Pad2_R0Pad1 net_Q0Pad2 net_R0Pad1 -0.0
CQ0Pad2_R0Pad2 net_Q0Pad2 net_R0Pad2 6.1e-16
CQ0Pad2_R1Pad1 net_Q0Pad2 net_R1Pad1 0.0
CQ0Pad2_R1Pad2 net_Q0Pad2 net_R1Pad2 5e-17
CQ0Pad2_R2Pad1 net_Q0Pad2 net_R2Pad1 0.0
CQ0Pad2_R2Pad2 net_Q0Pad2 net_R2Pad2 0.0
CQ0Pad2_R3Pad1 net_Q0Pad2 net_R3Pad1 0.0
CQ0Pad2_R3Pad2 net_Q0Pad2 net_R3Pad2 0.0
CQ0Pad2_R4Pad1 net_Q0Pad2 net_R4Pad1 0.0
CQ0Pad2_R4Pad2 net_Q0Pad2 net_R4Pad2 0.0
CQ0Pad2_R5Pad1 net_Q0Pad2 net_R5Pad1 0.0
CQ0Pad2_R5Pad2 net_Q0Pad2 net_R5Pad2 0.0
CQ0Pad2_R6Pad1 net_Q0Pad2 net_R6Pad1 0.0
CQ0Pad2_R6Pad2 net_Q0Pad2 net_R6Pad2 0.0
CQ0Pad2_R7Pad1 net_Q0Pad2 net_R7Pad1 0.0
CQ0Pad2_R7Pad2 net_Q0Pad2 net_R7Pad2 0.0
CQ1Pad1_G net_Q1Pad1 0 6.837999999999998e-14
CQ1Pad1_Q1Pad2 net_Q1Pad1 net_Q1Pad2 4.244e-14
CQ1Pad1_Q2Pad1 net_Q1Pad1 net_Q2Pad1 3e-17
CQ1Pad1_Q2Pad2 net_Q1Pad1 net_Q2Pad2 3e-17
CQ1Pad1_Q3Pad1 net_Q1Pad1 net_Q3Pad1 1e-17
CQ1Pad1_Q3Pad2 net_Q1Pad1 net_Q3Pad2 1e-17
CQ1Pad1_Q4Pad1 net_Q1Pad1 net_Q4Pad1 1e-17
CQ1Pad1_Q4Pad2 net_Q1Pad1 net_Q4Pad2 0.0
CQ1Pad1_Q5Pad1 net_Q1Pad1 net_Q5Pad1 0.0
CQ1Pad1_Q5Pad2 net_Q1Pad1 net_Q5Pad2 0.0
CQ1Pad1_Q6Pad1 net_Q1Pad1 net_Q6Pad1 0.0
CQ1Pad1_Q6Pad2 net_Q1Pad1 net_Q6Pad2 -0.0
CQ1Pad1_Q7Pad1 net_Q1Pad1 net_Q7Pad1 1e-17
CQ1Pad1_Q7Pad2 net_Q1Pad1 net_Q7Pad2 -0.0
CQ1Pad1_R0Pad1 net_Q1Pad1 net_R0Pad1 0.0
CQ1Pad1_R0Pad2 net_Q1Pad1 net_R0Pad2 6e-17
CQ1Pad1_R1Pad1 net_Q1Pad1 net_R1Pad1 0.0
CQ1Pad1_R1Pad2 net_Q1Pad1 net_R1Pad2 1.566e-14
CQ1Pad1_R2Pad1 net_Q1Pad1 net_R2Pad1 0.0
CQ1Pad1_R2Pad2 net_Q1Pad1 net_R2Pad2 0.0
CQ1Pad1_R3Pad1 net_Q1Pad1 net_R3Pad1 -0.0
CQ1Pad1_R3Pad2 net_Q1Pad1 net_R3Pad2 0.0
CQ1Pad1_R4Pad1 net_Q1Pad1 net_R4Pad1 0.0
CQ1Pad1_R4Pad2 net_Q1Pad1 net_R4Pad2 0.0
CQ1Pad1_R5Pad1 net_Q1Pad1 net_R5Pad1 0.0
CQ1Pad1_R5Pad2 net_Q1Pad1 net_R5Pad2 0.0
CQ1Pad1_R6Pad1 net_Q1Pad1 net_R6Pad1 0.0
CQ1Pad1_R6Pad2 net_Q1Pad1 net_R6Pad2 0.0
CQ1Pad1_R7Pad1 net_Q1Pad1 net_R7Pad1 0.0
CQ1Pad1_R7Pad2 net_Q1Pad1 net_R7Pad2 -0.0
CQ1Pad2_G net_Q1Pad2 0 7.289e-14
CQ1Pad2_Q2Pad1 net_Q1Pad2 net_Q2Pad1 3e-17
CQ1Pad2_Q2Pad2 net_Q1Pad2 net_Q2Pad2 3e-17
CQ1Pad2_Q3Pad1 net_Q1Pad2 net_Q3Pad1 0.0
CQ1Pad2_Q3Pad2 net_Q1Pad2 net_Q3Pad2 1e-17
CQ1Pad2_Q4Pad1 net_Q1Pad2 net_Q4Pad1 1e-17
CQ1Pad2_Q4Pad2 net_Q1Pad2 net_Q4Pad2 0.0
CQ1Pad2_Q5Pad1 net_Q1Pad2 net_Q5Pad1 -0.0
CQ1Pad2_Q5Pad2 net_Q1Pad2 net_Q5Pad2 0.0
CQ1Pad2_Q6Pad1 net_Q1Pad2 net_Q6Pad1 -0.0
CQ1Pad2_Q6Pad2 net_Q1Pad2 net_Q6Pad2 0.0
CQ1Pad2_Q7Pad1 net_Q1Pad2 net_Q7Pad1 -0.0
CQ1Pad2_Q7Pad2 net_Q1Pad2 net_Q7Pad2 1e-17
CQ1Pad2_R0Pad1 net_Q1Pad2 net_R0Pad1 0.0
CQ1Pad2_R0Pad2 net_Q1Pad2 net_R0Pad2 5e-17
CQ1Pad2_R1Pad1 net_Q1Pad2 net_R1Pad1 0.0
CQ1Pad2_R1Pad2 net_Q1Pad2 net_R1Pad2 6.1e-16
CQ1Pad2_R2Pad1 net_Q1Pad2 net_R2Pad1 0.0
CQ1Pad2_R2Pad2 net_Q1Pad2 net_R2Pad2 0.0
CQ1Pad2_R3Pad1 net_Q1Pad2 net_R3Pad1 0.0
CQ1Pad2_R3Pad2 net_Q1Pad2 net_R3Pad2 0.0
CQ1Pad2_R4Pad1 net_Q1Pad2 net_R4Pad1 0.0
CQ1Pad2_R4Pad2 net_Q1Pad2 net_R4Pad2 0.0
CQ1Pad2_R5Pad1 net_Q1Pad2 net_R5Pad1 0.0
CQ1Pad2_R5Pad2 net_Q1Pad2 net_R5Pad2 0.0
CQ1Pad2_R6Pad1 net_Q1Pad2 net_R6Pad1 0.0
CQ1Pad2_R6Pad2 net_Q1Pad2 net_R6Pad2 0.0
CQ1Pad2_R7Pad1 net_Q1Pad2 net_R7Pad1 -0.0
CQ1Pad2_R7Pad2 net_Q1Pad2 net_R7Pad2 0.0
CQ2Pad1_G net_Q2Pad1 0 6.817999999999999e-14
CQ2Pad1_Q2Pad2 net_Q2Pad1 net_Q2Pad2 4.249e-14
CQ2Pad1_Q3Pad1 net_Q2Pad1 net_Q3Pad1 1.04e-15
CQ2Pad1_Q3Pad2 net_Q2Pad1 net_Q3Pad2 9e-16
CQ2Pad1_Q4Pad1 net_Q2Pad1 net_Q4Pad1 3e-17
CQ2Pad1_Q4Pad2 net_Q2Pad1 net_Q4Pad2 2e-17
CQ2Pad1_Q5Pad1 net_Q2Pad1 net_Q5Pad1 0.0
CQ2Pad1_Q5Pad2 net_Q2Pad1 net_Q5Pad2 0.0
CQ2Pad1_Q6Pad1 net_Q2Pad1 net_Q6Pad1 0.0
CQ2Pad1_Q6Pad2 net_Q2Pad1 net_Q6Pad2 -0.0
CQ2Pad1_Q7Pad1 net_Q2Pad1 net_Q7Pad1 0.0
CQ2Pad1_Q7Pad2 net_Q2Pad1 net_Q7Pad2 0.0
CQ2Pad1_R0Pad1 net_Q2Pad1 net_R0Pad1 0.0
CQ2Pad1_R0Pad2 net_Q2Pad1 net_R0Pad2 0.0
CQ2Pad1_R1Pad1 net_Q2Pad1 net_R1Pad1 0.0
CQ2Pad1_R1Pad2 net_Q2Pad1 net_R1Pad2 0.0
CQ2Pad1_R2Pad1 net_Q2Pad1 net_R2Pad1 0.0
CQ2Pad1_R2Pad2 net_Q2Pad1 net_R2Pad2 1.5630000000000002e-14
CQ2Pad1_R3Pad1 net_Q2Pad1 net_R3Pad1 0.0
CQ2Pad1_R3Pad2 net_Q2Pad1 net_R3Pad2 6e-17
CQ2Pad1_R4Pad1 net_Q2Pad1 net_R4Pad1 0.0
CQ2Pad1_R4Pad2 net_Q2Pad1 net_R4Pad2 0.0
CQ2Pad1_R5Pad1 net_Q2Pad1 net_R5Pad1 0.0
CQ2Pad1_R5Pad2 net_Q2Pad1 net_R5Pad2 0.0
CQ2Pad1_R6Pad1 net_Q2Pad1 net_R6Pad1 0.0
CQ2Pad1_R6Pad2 net_Q2Pad1 net_R6Pad2 0.0
CQ2Pad1_R7Pad1 net_Q2Pad1 net_R7Pad1 0.0
CQ2Pad1_R7Pad2 net_Q2Pad1 net_R7Pad2 0.0
CQ2Pad2_G net_Q2Pad2 0 7.292999999999997e-14
CQ2Pad2_Q3Pad1 net_Q2Pad2 net_Q3Pad1 9.1e-16
CQ2Pad2_Q3Pad2 net_Q2Pad2 net_Q3Pad2 1.1000000000000001e-15
CQ2Pad2_Q4Pad1 net_Q2Pad2 net_Q4Pad1 5e-17
CQ2Pad2_Q4Pad2 net_Q2Pad2 net_Q4Pad2 4e-17
CQ2Pad2_Q5Pad1 net_Q2Pad2 net_Q5Pad1 0.0
CQ2Pad2_Q5Pad2 net_Q2Pad2 net_Q5Pad2 0.0
CQ2Pad2_Q6Pad1 net_Q2Pad2 net_Q6Pad1 0.0
CQ2Pad2_Q6Pad2 net_Q2Pad2 net_Q6Pad2 0.0
CQ2Pad2_Q7Pad1 net_Q2Pad2 net_Q7Pad1 0.0
CQ2Pad2_Q7Pad2 net_Q2Pad2 net_Q7Pad2 0.0
CQ2Pad2_R0Pad1 net_Q2Pad2 net_R0Pad1 0.0
CQ2Pad2_R0Pad2 net_Q2Pad2 net_R0Pad2 0.0
CQ2Pad2_R1Pad1 net_Q2Pad2 net_R1Pad1 0.0
CQ2Pad2_R1Pad2 net_Q2Pad2 net_R1Pad2 0.0
CQ2Pad2_R2Pad1 net_Q2Pad2 net_R2Pad1 0.0
CQ2Pad2_R2Pad2 net_Q2Pad2 net_R2Pad2 6.4e-16
CQ2Pad2_R3Pad1 net_Q2Pad2 net_R3Pad1 -0.0
CQ2Pad2_R3Pad2 net_Q2Pad2 net_R3Pad2 4e-17
CQ2Pad2_R4Pad1 net_Q2Pad2 net_R4Pad1 0.0
CQ2Pad2_R4Pad2 net_Q2Pad2 net_R4Pad2 0.0
CQ2Pad2_R5Pad1 net_Q2Pad2 net_R5Pad1 0.0
CQ2Pad2_R5Pad2 net_Q2Pad2 net_R5Pad2 0.0
CQ2Pad2_R6Pad1 net_Q2Pad2 net_R6Pad1 0.0
CQ2Pad2_R6Pad2 net_Q2Pad2 net_R6Pad2 0.0
CQ2Pad2_R7Pad1 net_Q2Pad2 net_R7Pad1 0.0
CQ2Pad2_R7Pad2 net_Q2Pad2 net_R7Pad2 0.0
CQ3Pad1_G net_Q3Pad1 0 6.806999999999997e-14
CQ3Pad1_Q3Pad2 net_Q3Pad1 net_Q3Pad2 4.25e-14
CQ3Pad1_Q4Pad1 net_Q3Pad1 net_Q4Pad1 5e-17
CQ3Pad1_Q4Pad2 net_Q3Pad1 net_Q4Pad2 4e-17
CQ3Pad1_Q5Pad1 net_Q3Pad1 net_Q5Pad1 1e-17
CQ3Pad1_Q5Pad2 net_Q3Pad1 net_Q5Pad2 0.0
CQ3Pad1_Q6Pad1 net_Q3Pad1 net_Q6Pad1 0.0
CQ3Pad1_Q6Pad2 net_Q3Pad1 net_Q6Pad2 -0.0
CQ3Pad1_Q7Pad1 net_Q3Pad1 net_Q7Pad1 0.0
CQ3Pad1_Q7Pad2 net_Q3Pad1 net_Q7Pad2 -0.0
CQ3Pad1_R0Pad1 net_Q3Pad1 net_R0Pad1 0.0
CQ3Pad1_R0Pad2 net_Q3Pad1 net_R0Pad2 0.0
CQ3Pad1_R1Pad1 net_Q3Pad1 net_R1Pad1 0.0
CQ3Pad1_R1Pad2 net_Q3Pad1 net_R1Pad2 0.0
CQ3Pad1_R2Pad1 net_Q3Pad1 net_R2Pad1 0.0
CQ3Pad1_R2Pad2 net_Q3Pad1 net_R2Pad2 6e-17
CQ3Pad1_R3Pad1 net_Q3Pad1 net_R3Pad1 0.0
CQ3Pad1_R3Pad2 net_Q3Pad1 net_R3Pad2 1.5630000000000002e-14
CQ3Pad1_R4Pad1 net_Q3Pad1 net_R4Pad1 0.0
CQ3Pad1_R4Pad2 net_Q3Pad1 net_R4Pad2 0.0
CQ3Pad1_R5Pad1 net_Q3Pad1 net_R5Pad1 0.0
CQ3Pad1_R5Pad2 net_Q3Pad1 net_R5Pad2 0.0
CQ3Pad1_R6Pad1 net_Q3Pad1 net_R6Pad1 0.0
CQ3Pad1_R6Pad2 net_Q3Pad1 net_R6Pad2 0.0
CQ3Pad1_R7Pad1 net_Q3Pad1 net_R7Pad1 0.0
CQ3Pad1_R7Pad2 net_Q3Pad1 net_R7Pad2 0.0
CQ3Pad2_G net_Q3Pad2 0 7.279999999999999e-14
CQ3Pad2_Q4Pad1 net_Q3Pad2 net_Q4Pad1 9.000000000000001e-17
CQ3Pad2_Q4Pad2 net_Q3Pad2 net_Q4Pad2 8e-17
CQ3Pad2_Q5Pad1 net_Q3Pad2 net_Q5Pad1 1e-17
CQ3Pad2_Q5Pad2 net_Q3Pad2 net_Q5Pad2 0.0
CQ3Pad2_Q6Pad1 net_Q3Pad2 net_Q6Pad1 0.0
CQ3Pad2_Q6Pad2 net_Q3Pad2 net_Q6Pad2 1e-17
CQ3Pad2_Q7Pad1 net_Q3Pad2 net_Q7Pad1 0.0
CQ3Pad2_Q7Pad2 net_Q3Pad2 net_Q7Pad2 -0.0
CQ3Pad2_R0Pad1 net_Q3Pad2 net_R0Pad1 0.0
CQ3Pad2_R0Pad2 net_Q3Pad2 net_R0Pad2 0.0
CQ3Pad2_R1Pad1 net_Q3Pad2 net_R1Pad1 0.0
CQ3Pad2_R1Pad2 net_Q3Pad2 net_R1Pad2 0.0
CQ3Pad2_R2Pad1 net_Q3Pad2 net_R2Pad1 0.0
CQ3Pad2_R2Pad2 net_Q3Pad2 net_R2Pad2 5e-17
CQ3Pad2_R3Pad1 net_Q3Pad2 net_R3Pad1 0.0
CQ3Pad2_R3Pad2 net_Q3Pad2 net_R3Pad2 6.499999999999999e-16
CQ3Pad2_R4Pad1 net_Q3Pad2 net_R4Pad1 0.0
CQ3Pad2_R4Pad2 net_Q3Pad2 net_R4Pad2 1e-17
CQ3Pad2_R5Pad1 net_Q3Pad2 net_R5Pad1 0.0
CQ3Pad2_R5Pad2 net_Q3Pad2 net_R5Pad2 0.0
CQ3Pad2_R6Pad1 net_Q3Pad2 net_R6Pad1 0.0
CQ3Pad2_R6Pad2 net_Q3Pad2 net_R6Pad2 0.0
CQ3Pad2_R7Pad1 net_Q3Pad2 net_R7Pad1 0.0
CQ3Pad2_R7Pad2 net_Q3Pad2 net_R7Pad2 0.0
CQ4Pad1_G net_Q4Pad1 0 7.432999999999998e-14
CQ4Pad1_Q4Pad2 net_Q4Pad1 net_Q4Pad2 4.245e-14
CQ4Pad1_Q5Pad1 net_Q4Pad1 net_Q5Pad1 1.9e-16
CQ4Pad1_Q5Pad2 net_Q4Pad1 net_Q5Pad2 1.8000000000000002e-16
CQ4Pad1_Q6Pad1 net_Q4Pad1 net_Q6Pad1 1e-17
CQ4Pad1_Q6Pad2 net_Q4Pad1 net_Q6Pad2 1e-17
CQ4Pad1_Q7Pad1 net_Q4Pad1 net_Q7Pad1 -0.0
CQ4Pad1_Q7Pad2 net_Q4Pad1 net_Q7Pad2 0.0
CQ4Pad1_R0Pad1 net_Q4Pad1 net_R0Pad1 -0.0
CQ4Pad1_R0Pad2 net_Q4Pad1 net_R0Pad2 0.0
CQ4Pad1_R1Pad1 net_Q4Pad1 net_R1Pad1 0.0
CQ4Pad1_R1Pad2 net_Q4Pad1 net_R1Pad2 0.0
CQ4Pad1_R2Pad1 net_Q4Pad1 net_R2Pad1 0.0
CQ4Pad1_R2Pad2 net_Q4Pad1 net_R2Pad2 0.0
CQ4Pad1_R3Pad1 net_Q4Pad1 net_R3Pad1 0.0
CQ4Pad1_R3Pad2 net_Q4Pad1 net_R3Pad2 0.0
CQ4Pad1_R4Pad1 net_Q4Pad1 net_R4Pad1 0.0
CQ4Pad1_R4Pad2 net_Q4Pad1 net_R4Pad2 6.4e-16
CQ4Pad1_R5Pad1 net_Q4Pad1 net_R5Pad1 0.0
CQ4Pad1_R5Pad2 net_Q4Pad1 net_R5Pad2 1e-17
CQ4Pad1_R6Pad1 net_Q4Pad1 net_R6Pad1 0.0
CQ4Pad1_R6Pad2 net_Q4Pad1 net_R6Pad2 0.0
CQ4Pad1_R7Pad1 net_Q4Pad1 net_R7Pad1 0.0
CQ4Pad1_R7Pad2 net_Q4Pad1 net_R7Pad2 0.0
CQ4Pad2_G net_Q4Pad2 0 6.996999999999997e-14
CQ4Pad2_Q5Pad1 net_Q4Pad2 net_Q5Pad1 1.8000000000000002e-16
CQ4Pad2_Q5Pad2 net_Q4Pad2 net_Q5Pad2 1.8000000000000002e-16
CQ4Pad2_Q6Pad1 net_Q4Pad2 net_Q6Pad1 1e-17
CQ4Pad2_Q6Pad2 net_Q4Pad2 net_Q6Pad2 1e-17
CQ4Pad2_Q7Pad1 net_Q4Pad2 net_Q7Pad1 0.0
CQ4Pad2_Q7Pad2 net_Q4Pad2 net_Q7Pad2 0.0
CQ4Pad2_R0Pad1 net_Q4Pad2 net_R0Pad1 -0.0
CQ4Pad2_R0Pad2 net_Q4Pad2 net_R0Pad2 0.0
CQ4Pad2_R1Pad1 net_Q4Pad2 net_R1Pad1 0.0
CQ4Pad2_R1Pad2 net_Q4Pad2 net_R1Pad2 0.0
CQ4Pad2_R2Pad1 net_Q4Pad2 net_R2Pad1 0.0
CQ4Pad2_R2Pad2 net_Q4Pad2 net_R2Pad2 0.0
CQ4Pad2_R3Pad1 net_Q4Pad2 net_R3Pad1 0.0
CQ4Pad2_R3Pad2 net_Q4Pad2 net_R3Pad2 0.0
CQ4Pad2_R4Pad1 net_Q4Pad2 net_R4Pad1 0.0
CQ4Pad2_R4Pad2 net_Q4Pad2 net_R4Pad2 1.311e-14
CQ4Pad2_R5Pad1 net_Q4Pad2 net_R5Pad1 0.0
CQ4Pad2_R5Pad2 net_Q4Pad2 net_R5Pad2 1e-17
CQ4Pad2_R6Pad1 net_Q4Pad2 net_R6Pad1 0.0
CQ4Pad2_R6Pad2 net_Q4Pad2 net_R6Pad2 0.0
CQ4Pad2_R7Pad1 net_Q4Pad2 net_R7Pad1 0.0
CQ4Pad2_R7Pad2 net_Q4Pad2 net_R7Pad2 0.0
CQ5Pad1_G net_Q5Pad1 0 7.436999999999999e-14
CQ5Pad1_Q5Pad2 net_Q5Pad1 net_Q5Pad2 4.244e-14
CQ5Pad1_Q6Pad1 net_Q5Pad1 net_Q6Pad1 1.2e-16
CQ5Pad1_Q6Pad2 net_Q5Pad1 net_Q6Pad2 6e-17
CQ5Pad1_Q7Pad1 net_Q5Pad1 net_Q7Pad1 2e-17
CQ5Pad1_Q7Pad2 net_Q5Pad1 net_Q7Pad2 1e-17
CQ5Pad1_R0Pad1 net_Q5Pad1 net_R0Pad1 0.0
CQ5Pad1_R0Pad2 net_Q5Pad1 net_R0Pad2 0.0
CQ5Pad1_R1Pad1 net_Q5Pad1 net_R1Pad1 0.0
CQ5Pad1_R1Pad2 net_Q5Pad1 net_R1Pad2 0.0
CQ5Pad1_R2Pad1 net_Q5Pad1 net_R2Pad1 0.0
CQ5Pad1_R2Pad2 net_Q5Pad1 net_R2Pad2 0.0
CQ5Pad1_R3Pad1 net_Q5Pad1 net_R3Pad1 0.0
CQ5Pad1_R3Pad2 net_Q5Pad1 net_R3Pad2 0.0
CQ5Pad1_R4Pad1 net_Q5Pad1 net_R4Pad1 0.0
CQ5Pad1_R4Pad2 net_Q5Pad1 net_R4Pad2 1e-17
CQ5Pad1_R5Pad1 net_Q5Pad1 net_R5Pad1 0.0
CQ5Pad1_R5Pad2 net_Q5Pad1 net_R5Pad2 6.4e-16
CQ5Pad1_R6Pad1 net_Q5Pad1 net_R6Pad1 0.0
CQ5Pad1_R6Pad2 net_Q5Pad1 net_R6Pad2 0.0
CQ5Pad1_R7Pad1 net_Q5Pad1 net_R7Pad1 0.0
CQ5Pad1_R7Pad2 net_Q5Pad1 net_R7Pad2 0.0
CQ5Pad2_G net_Q5Pad2 0 6.993999999999999e-14
CQ5Pad2_Q6Pad1 net_Q5Pad2 net_Q6Pad1 1.2e-16
CQ5Pad2_Q6Pad2 net_Q5Pad2 net_Q6Pad2 5e-17
CQ5Pad2_Q7Pad1 net_Q5Pad2 net_Q7Pad1 1e-17
CQ5Pad2_Q7Pad2 net_Q5Pad2 net_Q7Pad2 0.0
CQ5Pad2_R0Pad1 net_Q5Pad2 net_R0Pad1 0.0
CQ5Pad2_R0Pad2 net_Q5Pad2 net_R0Pad2 0.0
CQ5Pad2_R1Pad1 net_Q5Pad2 net_R1Pad1 0.0
CQ5Pad2_R1Pad2 net_Q5Pad2 net_R1Pad2 0.0
CQ5Pad2_R2Pad1 net_Q5Pad2 net_R2Pad1 0.0
CQ5Pad2_R2Pad2 net_Q5Pad2 net_R2Pad2 0.0
CQ5Pad2_R3Pad1 net_Q5Pad2 net_R3Pad1 0.0
CQ5Pad2_R3Pad2 net_Q5Pad2 net_R3Pad2 0.0
CQ5Pad2_R4Pad1 net_Q5Pad2 net_R4Pad1 0.0
CQ5Pad2_R4Pad2 net_Q5Pad2 net_R4Pad2 1e-17
CQ5Pad2_R5Pad1 net_Q5Pad2 net_R5Pad1 0.0
CQ5Pad2_R5Pad2 net_Q5Pad2 net_R5Pad2 1.312e-14
CQ5Pad2_R6Pad1 net_Q5Pad2 net_R6Pad1 0.0
CQ5Pad2_R6Pad2 net_Q5Pad2 net_R6Pad2 0.0
CQ5Pad2_R7Pad1 net_Q5Pad2 net_R7Pad1 0.0
CQ5Pad2_R7Pad2 net_Q5Pad2 net_R7Pad2 0.0
CQ6Pad1_G net_Q6Pad1 0 7.466000000000001e-14
CQ6Pad1_Q6Pad2 net_Q6Pad1 net_Q6Pad2 4.254e-14
CQ6Pad1_Q7Pad1 net_Q6Pad1 net_Q7Pad1 2e-17
CQ6Pad1_Q7Pad2 net_Q6Pad1 net_Q7Pad2 1e-17
CQ6Pad1_R0Pad1 net_Q6Pad1 net_R0Pad1 0.0
CQ6Pad1_R0Pad2 net_Q6Pad1 net_R0Pad2 0.0
CQ6Pad1_R1Pad1 net_Q6Pad1 net_R1Pad1 0.0
CQ6Pad1_R1Pad2 net_Q6Pad1 net_R1Pad2 0.0
CQ6Pad1_R2Pad1 net_Q6Pad1 net_R2Pad1 0.0
CQ6Pad1_R2Pad2 net_Q6Pad1 net_R2Pad2 0.0
CQ6Pad1_R3Pad1 net_Q6Pad1 net_R3Pad1 0.0
CQ6Pad1_R3Pad2 net_Q6Pad1 net_R3Pad2 0.0
CQ6Pad1_R4Pad1 net_Q6Pad1 net_R4Pad1 0.0
CQ6Pad1_R4Pad2 net_Q6Pad1 net_R4Pad2 0.0
CQ6Pad1_R5Pad1 net_Q6Pad1 net_R5Pad1 0.0
CQ6Pad1_R5Pad2 net_Q6Pad1 net_R5Pad2 1e-17
CQ6Pad1_R6Pad1 net_Q6Pad1 net_R6Pad1 0.0
CQ6Pad1_R6Pad2 net_Q6Pad1 net_R6Pad2 5.9e-16
CQ6Pad1_R7Pad1 net_Q6Pad1 net_R7Pad1 0.0
CQ6Pad1_R7Pad2 net_Q6Pad1 net_R7Pad2 0.0
CQ6Pad2_G net_Q6Pad2 0 7.039000000000002e-14
CQ6Pad2_Q7Pad1 net_Q6Pad2 net_Q7Pad1 1e-17
CQ6Pad2_Q7Pad2 net_Q6Pad2 net_Q7Pad2 2e-17
CQ6Pad2_R0Pad1 net_Q6Pad2 net_R0Pad1 0.0
CQ6Pad2_R0Pad2 net_Q6Pad2 net_R0Pad2 0.0
CQ6Pad2_R1Pad1 net_Q6Pad2 net_R1Pad1 0.0
CQ6Pad2_R1Pad2 net_Q6Pad2 net_R1Pad2 -0.0
CQ6Pad2_R2Pad1 net_Q6Pad2 net_R2Pad1 0.0
CQ6Pad2_R2Pad2 net_Q6Pad2 net_R2Pad2 0.0
CQ6Pad2_R3Pad1 net_Q6Pad2 net_R3Pad1 -0.0
CQ6Pad2_R3Pad2 net_Q6Pad2 net_R3Pad2 0.0
CQ6Pad2_R4Pad1 net_Q6Pad2 net_R4Pad1 0.0
CQ6Pad2_R4Pad2 net_Q6Pad2 net_R4Pad2 0.0
CQ6Pad2_R5Pad1 net_Q6Pad2 net_R5Pad1 0.0
CQ6Pad2_R5Pad2 net_Q6Pad2 net_R5Pad2 0.0
CQ6Pad2_R6Pad1 net_Q6Pad2 net_R6Pad1 0.0
CQ6Pad2_R6Pad2 net_Q6Pad2 net_R6Pad2 9.489999999999999e-15
CQ6Pad2_R7Pad1 net_Q6Pad2 net_R7Pad1 0.0
CQ6Pad2_R7Pad2 net_Q6Pad2 net_R7Pad2 0.0
CQ7Pad1_G net_Q7Pad1 0 7.48e-14
CQ7Pad1_Q7Pad2 net_Q7Pad1 net_Q7Pad2 4.256e-14
CQ7Pad1_R0Pad1 net_Q7Pad1 net_R0Pad1 0.0
CQ7Pad1_R0Pad2 net_Q7Pad1 net_R0Pad2 0.0
CQ7Pad1_R1Pad1 net_Q7Pad1 net_R1Pad1 0.0
CQ7Pad1_R1Pad2 net_Q7Pad1 net_R1Pad2 0.0
CQ7Pad1_R2Pad1 net_Q7Pad1 net_R2Pad1 0.0
CQ7Pad1_R2Pad2 net_Q7Pad1 net_R2Pad2 0.0
CQ7Pad1_R3Pad1 net_Q7Pad1 net_R3Pad1 -0.0
CQ7Pad1_R3Pad2 net_Q7Pad1 net_R3Pad2 0.0
CQ7Pad1_R4Pad1 net_Q7Pad1 net_R4Pad1 0.0
CQ7Pad1_R4Pad2 net_Q7Pad1 net_R4Pad2 0.0
CQ7Pad1_R5Pad1 net_Q7Pad1 net_R5Pad1 0.0
CQ7Pad1_R5Pad2 net_Q7Pad1 net_R5Pad2 0.0
CQ7Pad1_R6Pad1 net_Q7Pad1 net_R6Pad1 0.0
CQ7Pad1_R6Pad2 net_Q7Pad1 net_R6Pad2 0.0
CQ7Pad1_R7Pad1 net_Q7Pad1 net_R7Pad1 0.0
CQ7Pad1_R7Pad2 net_Q7Pad1 net_R7Pad2 5.9e-16
CQ7Pad2_G net_Q7Pad2 0 7.054e-14
CQ7Pad2_R0Pad1 net_Q7Pad2 net_R0Pad1 -0.0
CQ7Pad2_R0Pad2 net_Q7Pad2 net_R0Pad2 0.0
CQ7Pad2_R1Pad1 net_Q7Pad2 net_R1Pad1 -0.0
CQ7Pad2_R1Pad2 net_Q7Pad2 net_R1Pad2 -0.0
CQ7Pad2_R2Pad1 net_Q7Pad2 net_R2Pad1 -0.0
CQ7Pad2_R2Pad2 net_Q7Pad2 net_R2Pad2 0.0
CQ7Pad2_R3Pad1 net_Q7Pad2 net_R3Pad1 0.0
CQ7Pad2_R3Pad2 net_Q7Pad2 net_R3Pad2 0.0
CQ7Pad2_R4Pad1 net_Q7Pad2 net_R4Pad1 0.0
CQ7Pad2_R4Pad2 net_Q7Pad2 net_R4Pad2 0.0
CQ7Pad2_R5Pad1 net_Q7Pad2 net_R5Pad1 -0.0
CQ7Pad2_R5Pad2 net_Q7Pad2 net_R5Pad2 0.0
CQ7Pad2_R6Pad1 net_Q7Pad2 net_R6Pad1 0.0
CQ7Pad2_R6Pad2 net_Q7Pad2 net_R6Pad2 0.0
CQ7Pad2_R7Pad1 net_Q7Pad2 net_R7Pad1 0.0
CQ7Pad2_R7Pad2 net_Q7Pad2 net_R7Pad2 9.489999999999999e-15
CR0Pad1_G net_R0Pad1 0 4.476e-14
CR0Pad1_R0Pad2 net_R0Pad1 net_R0Pad2 0.0
CR0Pad1_R1Pad1 net_R0Pad1 net_R1Pad1 0.0
CR0Pad1_R1Pad2 net_R0Pad1 net_R1Pad2 0.0
CR0Pad1_R2Pad1 net_R0Pad1 net_R2Pad1 0.0
CR0Pad1_R2Pad2 net_R0Pad1 net_R2Pad2 0.0
CR0Pad1_R3Pad1 net_R0Pad1 net_R3Pad1 0.0
CR0Pad1_R3Pad2 net_R0Pad1 net_R3Pad2 0.0
CR0Pad1_R4Pad1 net_R0Pad1 net_R4Pad1 0.0
CR0Pad1_R4Pad2 net_R0Pad1 net_R4Pad2 0.0
CR0Pad1_R5Pad1 net_R0Pad1 net_R5Pad1 0.0
CR0Pad1_R5Pad2 net_R0Pad1 net_R5Pad2 0.0
CR0Pad1_R6Pad1 net_R0Pad1 net_R6Pad1 0.0
CR0Pad1_R6Pad2 net_R0Pad1 net_R6Pad2 0.0
CR0Pad1_R7Pad1 net_R0Pad1 net_R7Pad1 0.0
CR0Pad1_R7Pad2 net_R0Pad1 net_R7Pad2 0.0
CR0Pad2_G net_R0Pad2 0 9.890000000000003e-15
CR0Pad2_R1Pad1 net_R0Pad2 net_R1Pad1 0.0
CR0Pad2_R1Pad2 net_R0Pad2 net_R1Pad2 0.0
CR0Pad2_R2Pad1 net_R0Pad2 net_R2Pad1 0.0
CR0Pad2_R2Pad2 net_R0Pad2 net_R2Pad2 0.0
CR0Pad2_R3Pad1 net_R0Pad2 net_R3Pad1 0.0
CR0Pad2_R3Pad2 net_R0Pad2 net_R3Pad2 0.0
CR0Pad2_R4Pad1 net_R0Pad2 net_R4Pad1 0.0
CR0Pad2_R4Pad2 net_R0Pad2 net_R4Pad2 0.0
CR0Pad2_R5Pad1 net_R0Pad2 net_R5Pad1 0.0
CR0Pad2_R5Pad2 net_R0Pad2 net_R5Pad2 0.0
CR0Pad2_R6Pad1 net_R0Pad2 net_R6Pad1 0.0
CR0Pad2_R6Pad2 net_R0Pad2 net_R6Pad2 0.0
CR0Pad2_R7Pad1 net_R0Pad2 net_R7Pad1 0.0
CR0Pad2_R7Pad2 net_R0Pad2 net_R7Pad2 0.0
CR1Pad1_G net_R1Pad1 0 4.476e-14
CR1Pad1_R1Pad2 net_R1Pad1 net_R1Pad2 0.0
CR1Pad1_R2Pad1 net_R1Pad1 net_R2Pad1 0.0
CR1Pad1_R2Pad2 net_R1Pad1 net_R2Pad2 0.0
CR1Pad1_R3Pad1 net_R1Pad1 net_R3Pad1 0.0
CR1Pad1_R3Pad2 net_R1Pad1 net_R3Pad2 0.0
CR1Pad1_R4Pad1 net_R1Pad1 net_R4Pad1 0.0
CR1Pad1_R4Pad2 net_R1Pad1 net_R4Pad2 0.0
CR1Pad1_R5Pad1 net_R1Pad1 net_R5Pad1 0.0
CR1Pad1_R5Pad2 net_R1Pad1 net_R5Pad2 0.0
CR1Pad1_R6Pad1 net_R1Pad1 net_R6Pad1 0.0
CR1Pad1_R6Pad2 net_R1Pad1 net_R6Pad2 0.0
CR1Pad1_R7Pad1 net_R1Pad1 net_R7Pad1 0.0
CR1Pad1_R7Pad2 net_R1Pad1 net_R7Pad2 0.0
CR1Pad2_G net_R1Pad2 0 9.890000000000003e-15
CR1Pad2_R2Pad1 net_R1Pad2 net_R2Pad1 0.0
CR1Pad2_R2Pad2 net_R1Pad2 net_R2Pad2 0.0
CR1Pad2_R3Pad1 net_R1Pad2 net_R3Pad1 -0.0
CR1Pad2_R3Pad2 net_R1Pad2 net_R3Pad2 0.0
CR1Pad2_R4Pad1 net_R1Pad2 net_R4Pad1 0.0
CR1Pad2_R4Pad2 net_R1Pad2 net_R4Pad2 0.0
CR1Pad2_R5Pad1 net_R1Pad2 net_R5Pad1 0.0
CR1Pad2_R5Pad2 net_R1Pad2 net_R5Pad2 0.0
CR1Pad2_R6Pad1 net_R1Pad2 net_R6Pad1 0.0
CR1Pad2_R6Pad2 net_R1Pad2 net_R6Pad2 0.0
CR1Pad2_R7Pad1 net_R1Pad2 net_R7Pad1 0.0
CR1Pad2_R7Pad2 net_R1Pad2 net_R7Pad2 0.0
CR2Pad1_G net_R2Pad1 0 4.476e-14
CR2Pad1_R2Pad2 net_R2Pad1 net_R2Pad2 0.0
CR2Pad1_R3Pad1 net_R2Pad1 net_R3Pad1 0.0
CR2Pad1_R3Pad2 net_R2Pad1 net_R3Pad2 0.0
CR2Pad1_R4Pad1 net_R2Pad1 net_R4Pad1 0.0
CR2Pad1_R4Pad2 net_R2Pad1 net_R4Pad2 0.0
CR2Pad1_R5Pad1 net_R2Pad1 net_R5Pad1 0.0
CR2Pad1_R5Pad2 net_R2Pad1 net_R5Pad2 0.0
CR2Pad1_R6Pad1 net_R2Pad1 net_R6Pad1 -0.0
CR2Pad1_R6Pad2 net_R2Pad1 net_R6Pad2 0.0
CR2Pad1_R7Pad1 net_R2Pad1 net_R7Pad1 0.0
CR2Pad1_R7Pad2 net_R2Pad1 net_R7Pad2 0.0
CR2Pad2_G net_R2Pad2 0 9.89e-15
CR2Pad2_R3Pad1 net_R2Pad2 net_R3Pad1 0.0
CR2Pad2_R3Pad2 net_R2Pad2 net_R3Pad2 0.0
CR2Pad2_R4Pad1 net_R2Pad2 net_R4Pad1 0.0
CR2Pad2_R4Pad2 net_R2Pad2 net_R4Pad2 0.0
CR2Pad2_R5Pad1 net_R2Pad2 net_R5Pad1 0.0
CR2Pad2_R5Pad2 net_R2Pad2 net_R5Pad2 0.0
CR2Pad2_R6Pad1 net_R2Pad2 net_R6Pad1 0.0
CR2Pad2_R6Pad2 net_R2Pad2 net_R6Pad2 0.0
CR2Pad2_R7Pad1 net_R2Pad2 net_R7Pad1 0.0
CR2Pad2_R7Pad2 net_R2Pad2 net_R7Pad2 0.0
CR3Pad1_G net_R3Pad1 0 4.476e-14
CR3Pad1_R3Pad2 net_R3Pad1 net_R3Pad2 0.0
CR3Pad1_R4Pad1 net_R3Pad1 net_R4Pad1 -0.0
CR3Pad1_R4Pad2 net_R3Pad1 net_R4Pad2 0.0
CR3Pad1_R5Pad1 net_R3Pad1 net_R5Pad1 0.0
CR3Pad1_R5Pad2 net_R3Pad1 net_R5Pad2 0.0
CR3Pad1_R6Pad1 net_R3Pad1 net_R6Pad1 -0.0
CR3Pad1_R6Pad2 net_R3Pad1 net_R6Pad2 -0.0
CR3Pad1_R7Pad1 net_R3Pad1 net_R7Pad1 0.0
CR3Pad1_R7Pad2 net_R3Pad1 net_R7Pad2 0.0
CR3Pad2_G net_R3Pad2 0 9.879999999999995e-15
CR3Pad2_R4Pad1 net_R3Pad2 net_R4Pad1 0.0
CR3Pad2_R4Pad2 net_R3Pad2 net_R4Pad2 0.0
CR3Pad2_R5Pad1 net_R3Pad2 net_R5Pad1 0.0
CR3Pad2_R5Pad2 net_R3Pad2 net_R5Pad2 0.0
CR3Pad2_R6Pad1 net_R3Pad2 net_R6Pad1 0.0
CR3Pad2_R6Pad2 net_R3Pad2 net_R6Pad2 0.0
CR3Pad2_R7Pad1 net_R3Pad2 net_R7Pad1 0.0
CR3Pad2_R7Pad2 net_R3Pad2 net_R7Pad2 0.0
CR4Pad1_G net_R4Pad1 0 4.476e-14
CR4Pad1_R4Pad2 net_R4Pad1 net_R4Pad2 0.0
CR4Pad1_R5Pad1 net_R4Pad1 net_R5Pad1 0.0
CR4Pad1_R5Pad2 net_R4Pad1 net_R5Pad2 0.0
CR4Pad1_R6Pad1 net_R4Pad1 net_R6Pad1 -0.0
CR4Pad1_R6Pad2 net_R4Pad1 net_R6Pad2 0.0
CR4Pad1_R7Pad1 net_R4Pad1 net_R7Pad1 -0.0
CR4Pad1_R7Pad2 net_R4Pad1 net_R7Pad2 0.0
CR4Pad2_G net_R4Pad2 0 1.0649999999999999e-14
CR4Pad2_R5Pad1 net_R4Pad2 net_R5Pad1 0.0
CR4Pad2_R5Pad2 net_R4Pad2 net_R5Pad2 0.0
CR4Pad2_R6Pad1 net_R4Pad2 net_R6Pad1 0.0
CR4Pad2_R6Pad2 net_R4Pad2 net_R6Pad2 0.0
CR4Pad2_R7Pad1 net_R4Pad2 net_R7Pad1 0.0
CR4Pad2_R7Pad2 net_R4Pad2 net_R7Pad2 0.0
CR5Pad1_G net_R5Pad1 0 4.476e-14
CR5Pad1_R5Pad2 net_R5Pad1 net_R5Pad2 0.0
CR5Pad1_R6Pad1 net_R5Pad1 net_R6Pad1 0.0
CR5Pad1_R6Pad2 net_R5Pad1 net_R6Pad2 0.0
CR5Pad1_R7Pad1 net_R5Pad1 net_R7Pad1 0.0
CR5Pad1_R7Pad2 net_R5Pad1 net_R7Pad2 0.0
CR5Pad2_G net_R5Pad2 0 1.0649999999999998e-14
CR5Pad2_R6Pad1 net_R5Pad2 net_R6Pad1 0.0
CR5Pad2_R6Pad2 net_R5Pad2 net_R6Pad2 0.0
CR5Pad2_R7Pad1 net_R5Pad2 net_R7Pad1 0.0
CR5Pad2_R7Pad2 net_R5Pad2 net_R7Pad2 0.0
CR6Pad1_G net_R6Pad1 0 4.476e-14
CR6Pad1_R6Pad2 net_R6Pad1 net_R6Pad2 0.0
CR6Pad1_R7Pad1 net_R6Pad1 net_R7Pad1 0.0
CR6Pad1_R7Pad2 net_R6Pad1 net_R7Pad2 0.0
CR6Pad2_G net_R6Pad2 0 1.313e-14
CR6Pad2_R7Pad1 net_R6Pad2 net_R7Pad1 0.0
CR6Pad2_R7Pad2 net_R6Pad2 net_R7Pad2 0.0
CR7Pad1_G net_R7Pad1 0 4.476e-14
CR7Pad1_R7Pad2 net_R7Pad1 net_R7Pad2 0.0
CR7Pad2_G net_R7Pad2 0 1.3160000000000001e-14
CR0Pad1_F0 net_R0Pad1 net_F0 8.84e-15
CR1Pad1_F1 net_R1Pad1 net_F1 8.84e-15
CR2Pad1_F2 net_R2Pad1 net_F2 8.84e-15
CR3Pad1_F3 net_R3Pad1 net_F3 8.84e-15
CR4Pad1_F4 net_R4Pad1 net_F4 8.84e-15
CR5Pad1_F5 net_R5Pad1 net_F5 8.84e-15
CR6Pad1_F6 net_R6Pad1 net_F6 8.84e-15
CR7Pad1_F7 net_R7Pad1 net_F7 8.84e-15
LQ0Pad1_Q0Pad2 net_Q0Pad1 net_Q0Pad2 1.25e-08
LQ1Pad1_Q1Pad2 net_Q1Pad1 net_Q1Pad2 1.25e-08
LQ2Pad1_Q2Pad2 net_Q2Pad1 net_Q2Pad2 1.25e-08
LQ3Pad1_Q3Pad2 net_Q3Pad1 net_Q3Pad2 1.25e-08
LQ4Pad1_Q4Pad2 net_Q4Pad1 net_Q4Pad2 1.25e-08
LQ5Pad1_Q5Pad2 net_Q5Pad1 net_Q5Pad2 1.25e-08
LQ6Pad1_Q6Pad2 net_Q6Pad1 net_Q6Pad2 1.25e-08
LQ7Pad1_Q7Pad2 net_Q7Pad1 net_Q7Pad2 1.25e-08
RFL 0 net_FL 50
RFR 0 net_FR 50
TR0Pad1_R0Pad2 net_R0Pad1 0 net_R0Pad2 0 Z0=50 TD=3.3333333333333335e-11
TR1Pad1_R1Pad2 net_R1Pad1 0 net_R1Pad2 0 Z0=50 TD=3.3333333333333335e-11
TR2Pad1_R2Pad2 net_R2Pad1 0 net_R2Pad2 0 Z0=50 TD=3.3333333333333335e-11
TR3Pad1_R3Pad2 net_R3Pad1 0 net_R3Pad2 0 Z0=50 TD=3.3333333333333335e-11
TR4Pad1_R4Pad2 net_R4Pad1 0 net_R4Pad2 0 Z0=50 TD=3.3333333333333335e-11
TR5Pad1_R5Pad2 net_R5Pad1 0 net_R5Pad2 0 Z0=50 TD=3.3333333333333335e-11
TR6Pad1_R6Pad2 net_R6Pad1 0 net_R6Pad2 0 Z0=50 TD=3.3333333333333335e-11
TR7Pad1_R7Pad2 net_R7Pad1 0 net_R7Pad2 0 Z0=50 TD=3.3333333333333335e-11
TFL_F0 net_FL 0 net_F0 0 Z0=50 TD=1.0164659979556624e-11
TF0_F1 net_F0 0 net_F1 0 Z0=50 TD=4.714045207910317e-12
TF1_F2 net_F1 0 net_F2 0 Z0=50 TD=1.0606601717798212e-11
TF2_F3 net_F2 0 net_F3 0 Z0=50 TD=4.714045207910317e-12
TF3_F4 net_F3 0 net_F4 0 Z0=50 TD=3.522781169641459e-11
TF4_F5 net_F4 0 net_F5 0 Z0=50 TD=7.0710678118654645e-12
TF5_F6 net_F5 0 net_F6 0 Z0=50 TD=3.256956285252521e-11
TF6_F7 net_F6 0 net_F7 0 Z0=50 TD=1.4142135623730958e-11
TF7_FR net_F7 0 net_FR 0 Z0=50 TD=1.696608723395269e-11
RPort1 net_Q0Pad1 net_Q0Pad2 PORTNUM=1 RZ=50
.PORT net_Q0Pad1 net_Q0Pad2 1 RPort1
RPort2 net_Q1Pad1 net_Q1Pad2 PORTNUM=2 RZ=50
.PORT net_Q1Pad1 net_Q1Pad2 2 RPort2
RPort3 net_Q2Pad1 net_Q2Pad2 PORTNUM=3 RZ=50
.PORT net_Q2Pad1 net_Q2Pad2 3 RPort3
RPort4 net_Q3Pad1 net_Q3Pad2 PORTNUM=4 RZ=50
.PORT net_Q3Pad1 net_Q3Pad2 4 RPort4
RPort5 net_Q4Pad1 net_Q4Pad2 PORTNUM=5 RZ=50
.PORT net_Q4Pad1 net_Q4Pad2 5 RPort5
RPort6 net_Q5Pad1 net_Q5Pad2 PORTNUM=6 RZ=50
.PORT net_Q5Pad1 net_Q5Pad2 6 RPort6
RPort7 net_Q6Pad1 net_Q6Pad2 PORTNUM=7 RZ=50
.PORT net_Q6Pad1 net_Q6Pad2 7 RPort7
RPort8 net_Q7Pad1 net_Q7Pad2 PORTNUM=8 RZ=50
.PORT net_Q7Pad1 net_Q7Pad2 8 RPort8
RPort9 net_R0Pad1 net_R0Pad2 PORTNUM=9 RZ=50
.PORT net_R0Pad1 net_R0Pad2 9 RPort9
RPort10 net_R1Pad1 net_R1Pad2 PORTNUM=10 RZ=50
.PORT net_R1Pad1 net_R1Pad2 10 RPort10
RPort11 net_R2Pad1 net_R2Pad2 PORTNUM=11 RZ=50
.PORT net_R2Pad1 net_R2Pad2 11 RPort11
RPort12 net_R3Pad1 net_R3Pad2 PORTNUM=12 RZ=50
.PORT net_R3Pad1 net_R3Pad2 12 RPort12
RPort13 net_R4Pad1 net_R4Pad2 PORTNUM=13 RZ=50
.PORT net_R4Pad1 net_R4Pad2 13 RPort13
RPort14 net_R5Pad1 net_R5Pad2 PORTNUM=14 RZ=50
.PORT net_R5Pad1 net_R5Pad2 14 RPort14
RPort15 net_R6Pad1 net_R6Pad2 PORTNUM=15 RZ=50
.PORT net_R6Pad1 net_R6Pad2 15 RPort15
RPort16 net_R7Pad1 net_R7Pad2 PORTNUM=16 RZ=50
.PORT net_R7Pad1 net_R7Pad2 16 RPort16

.LNA
+ LIN 1000 4000000000.0 20000000000.0
+ FLAG='LNA'

.end
reports:
  Y Parameter Table 1: Y(1,1), Y(1,2), Y(1,3), Y(1,4), Y(1,5), Y(1,6), Y(1,7), Y(1,8), Y(1,9), Y(1,10), Y(1,11), Y(1,12), Y(1,13), Y(1,14), Y(1,15), Y(1,16), Y(2,1), Y(2,2), Y(2,3), Y(2,4), Y(2,5), Y(2,6), Y(2,7), Y(2,8), Y(2,9), Y(2,10), Y(2,11), Y(2,12), Y(2,13), Y(2,14), Y(2,15), Y(2,16), Y(3,1), Y(3,2), Y(3,3), Y(3,4), Y(3,5), Y(3,6), Y(3,7), Y(3,8)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 vs Freq on LNA : LNA
