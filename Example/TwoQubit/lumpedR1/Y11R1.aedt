# Ansys Electronics Desktop project, version 2021.1
materials:
  vacuum: permittivity=1
  copper: permeability=0.999991 conductivity=58000000
  silicon: permittivity=11.9

design Netlist (Circuit Netlist)
options: Language=HSPICE IntegrationMethod=FFT
netlist:
.option PARHIER='local'
.option max_messages=1
.option num_threads=4

CQ0Pad1_G net_Q0Pad1 0 6.339e-14
CQ0Pad1_Q0Pad2 net_Q0Pad1 net_Q0Pad2 4.295e-14
CQ0Pad1_Q1Pad1 net_Q0Pad1 net_Q1Pad1 3.79e-15
CQ0Pad1_Q1Pad2 net_Q0Pad1 net_Q1Pad2 2.53e-15
CQ0Pad1_R0Pad1 net_Q0Pad1 net_R0Pad1 0.0
CQ0Pad1_R0Pad2 net_Q0Pad1 net_R0Pad2 1.157e-14
CQ0Pad1_R1Pad1 net_Q0Pad1 net_R1Pad1 0.0
CQ0Pad1_R1Pad2 net_Q0Pad1 Port1 5e-17
CQ0Pad2_Q0Pad1 net_Q0Pad2 net_Q0Pad1 4.295e-14
CQ0Pad2_G net_Q0Pad2 0 6.732e-14
CQ0Pad2_Q1Pad1 net_Q0Pad2 net_Q1Pad1 2.53e-15
CQ0Pad2_Q1Pad2 net_Q0Pad2 net_Q1Pad2 3.83e-15
CQ0Pad2_R0Pad1 net_Q0Pad2 net_R0Pad1 0.0
CQ0Pad2_R0Pad2 net_Q0Pad2 net_R0Pad2 1.2299999999999999e-15
CQ0Pad2_R1Pad1 net_Q0Pad2 net_R1Pad1 0.0
CQ0Pad2_R1Pad2 net_Q0Pad2 Port1 4e-17
CQ1Pad1_Q0Pad1 net_Q1Pad1 net_Q0Pad1 3.79e-15
CQ1Pad1_Q0Pad2 net_Q1Pad1 net_Q0Pad2 2.53e-15
CQ1Pad1_G net_Q1Pad1 0 6.207e-14
CQ1Pad1_Q1Pad2 net_Q1Pad1 net_Q1Pad2 2.895e-14
CQ1Pad1_R0Pad1 net_Q1Pad1 net_R0Pad1 0.0
CQ1Pad1_R0Pad2 net_Q1Pad1 net_R0Pad2 4e-17
CQ1Pad1_R1Pad1 net_Q1Pad1 net_R1Pad1 0.0
CQ1Pad1_R1Pad2 net_Q1Pad1 Port1 6.6199999999999995e-15
CQ1Pad2_Q0Pad1 net_Q1Pad2 net_Q0Pad1 2.53e-15
CQ1Pad2_Q0Pad2 net_Q1Pad2 net_Q0Pad2 3.83e-15
CQ1Pad2_Q1Pad1 net_Q1Pad2 net_Q1Pad1 2.895e-14
CQ1Pad2_G net_Q1Pad2 0 6.517999999999999e-14
CQ1Pad2_R0Pad1 net_Q1Pad2 net_R0Pad1 0.0
CQ1Pad2_R0Pad2 net_Q1Pad2 net_R0Pad2 4e-17
CQ1Pad2_R1Pad1 net_Q1Pad2 net_R1Pad1 0.0
CQ1Pad2_R1Pad2 net_Q1Pad2 Port1 1.16e-15
CR0Pad1_Q0Pad1 net_R0Pad1 net_Q0Pad1 0.0
CR0Pad1_Q0Pad2 net_R0Pad1 net_Q0Pad2 0.0
CR0Pad1_Q1Pad1 net_R0Pad1 net_Q1Pad1 0.0
CR0Pad1_Q1Pad2 net_R0Pad1 net_Q1Pad2 0.0
CR0Pad1_G net_R0Pad1 0 4.476e-14
CR0Pad1_R0Pad2 net_R0Pad1 net_R0Pad2 0.0
CR0Pad1_R1Pad1 net_R0Pad1 net_R1Pad1 0.0
CR0Pad1_R1Pad2 net_R0Pad1 Port1 0.0
CR0Pad2_Q0Pad1 net_R0Pad2 net_Q0Pad1 1.157e-14
CR0Pad2_Q0Pad2 net_R0Pad2 net_Q0Pad2 1.2299999999999999e-15
CR0Pad2_Q1Pad1 net_R0Pad2 net_Q1Pad1 4e-17
CR0Pad2_Q1Pad2 net_R0Pad2 net_Q1Pad2 4e-17
CR0Pad2_R0Pad1 net_R0Pad2 net_R0Pad1 0.0
CR0Pad2_G net_R0Pad2 0 1.2e-14
CR0Pad2_R1Pad1 net_R0Pad2 net_R1Pad1 0.0
CR0Pad2_R1Pad2 net_R0Pad2 Port1 0.0
CR1Pad1_Q0Pad1 net_R1Pad1 net_Q0Pad1 0.0
CR1Pad1_Q0Pad2 net_R1Pad1 net_Q0Pad2 0.0
CR1Pad1_Q1Pad1 net_R1Pad1 net_Q1Pad1 0.0
CR1Pad1_Q1Pad2 net_R1Pad1 net_Q1Pad2 0.0
CR1Pad1_R0Pad1 net_R1Pad1 net_R0Pad1 0.0
CR1Pad1_R0Pad2 net_R1Pad1 net_R0Pad2 0.0
CR1Pad1_G net_R1Pad1 0 4.476e-14
CR1Pad1_R1Pad2 net_R1Pad1 Port1 0.0
CR1Pad2_Q0Pad1 Port1 net_Q0Pad1 5e-17
CR1Pad2_Q0Pad2 Port1 net_Q0Pad2 4e-17
CR1Pad2_Q1Pad1 Port1 net_Q1Pad1 6.6199999999999995e-15
CR1Pad2_Q1Pad2 Port1 net_Q1Pad2 1.16e-15
CR1Pad2_R0Pad1 Port1 net_R0Pad1 0.0
CR1Pad2_R0Pad2 Port1 net_R0Pad2 0.0
CR1Pad2_R1Pad1 Port1 net_R1Pad1 0.0
CR1Pad2_G Port1 0 1.575e-14
CR0Pad1_F0 net_R0Pad1 net_F0 8.84e-15
CR1Pad1_F1 net_R1Pad1 net_F1 8.84e-15
LQ0Pad1_Q0Pad2 net_Q0Pad1 net_Q0Pad2 1.25e-08
LQ1Pad1_Q1Pad2 net_Q1Pad1 net_Q1Pad2 1.25e-08
RFL 0 net_FL 50
RFR 0 net_FR 50
TR0Pad1_R0Pad2 net_R0Pad1 0 net_R0Pad2 0 Z0=50 TD=8.041666666666666e-11
TR1Pad1_R1Pad2 net_R1Pad1 0 Port1 0 Z0=50 TD=7.875e-11
TFL_F0 net_FL 0 net_F0 0 Z0=50 TD=3.813077291797825e-11
TF0_F1 net_F0 0 net_F1 0 Z0=50 TD=1.8429499999631133e-11
TF1_FR net_F1 0 net_FR 0 Z0=50 TD=3.79602454886843e-11
RPort1 Port1 0 PORTNUM=1 RZ=50
.PORT Port1 0 1 RPort1

.LNA
+ LIN 200 4000000000.0 7000000000.0
+ FLAG='LNA'

.end
reports:
  Y Parameter Table 1: Y(1,1) vs Freq on LNA : LNA
