# Ansys Electronics Desktop project, version 2019.3
materials:
  vacuum: permittivity=1
  copper: permeability=0.999991 conductivity=58000000
  silicon: permittivity=11.9

design Netlist (Circuit Netlist)
options: Language=HSPICE IntegrationMethod=FFT
netlist:
.option PARHIER='local'
.option max_messages=1
.option num_threads=4

CQ0Pad1_G net_Q0Pad1 0 9.925999999999999e-14
CQ0Pad1_Q0Pad2 net_Q0Pad1 net_Q0Pad2 6.426e-14
CQ0Pad1_Q1Pad1 net_Q0Pad1 net_Q1Pad1 1.093e-14
CQ0Pad1_Q1Pad2 net_Q0Pad1 net_Q1Pad2 5.23e-15
CQ0Pad1_R0Pad1 net_Q0Pad1 net_R0Pad1 0.0
CQ0Pad1_R0Pad2 net_Q0Pad1 net_R0Pad2 2.996e-14
CQ0Pad1_R1Pad1 net_Q0Pad1 net_R1Pad1 0.0
CQ0Pad1_R1Pad2 net_Q0Pad1 net_R1Pad2 6.999999999999999e-17
CQ0Pad2_G net_Q0Pad2 0 1.0769999999999999e-13
CQ0Pad2_Q1Pad1 net_Q0Pad2 net_Q1Pad1 5.2500000000000005e-15
CQ0Pad2_Q1Pad2 net_Q0Pad2 net_Q1Pad2 1.097e-14
CQ0Pad2_R0Pad1 net_Q0Pad2 net_R0Pad1 0.0
CQ0Pad2_R0Pad2 net_Q0Pad2 net_R0Pad2 1.81e-15
CQ0Pad2_R1Pad1 net_Q0Pad2 net_R1Pad1 0.0
CQ0Pad2_R1Pad2 net_Q0Pad2 net_R1Pad2 6e-17
CQ1Pad1_G net_Q1Pad1 0 9.712000000000002e-14
CQ1Pad1_Q1Pad2 net_Q1Pad1 net_Q1Pad2 4.004e-14
CQ1Pad1_R0Pad1 net_Q1Pad1 net_R0Pad1 0.0
CQ1Pad1_R0Pad2 net_Q1Pad1 net_R0Pad2 6.999999999999999e-17
CQ1Pad1_R1Pad1 net_Q1Pad1 net_R1Pad1 0.0
CQ1Pad1_R1Pad2 net_Q1Pad1 net_R1Pad2 1.7659999999999997e-14
CQ1Pad2_G net_Q1Pad2 0 1.0479000000000001e-13
CQ1Pad2_R0Pad1 net_Q1Pad2 net_R0Pad1 0.0
CQ1Pad2_R0Pad2 net_Q1Pad2 net_R0Pad2 6e-17
CQ1Pad2_R1Pad1 net_Q1Pad2 net_R1Pad1 0.0
CQ1Pad2_R1Pad2 net_Q1Pad2 net_R1Pad2 1.97e-15
CR0Pad1_G net_R0Pad1 0 4.476e-14
CR0Pad1_R0Pad2 net_R0Pad1 net_R0Pad2 0.0
CR0Pad1_R1Pad1 net_R0Pad1 net_R1Pad1 0.0
CR0Pad1_R1Pad2 net_R0Pad1 net_R1Pad2 0.0
CR0Pad2_G net_R0Pad2 0 2.4479999999999994e-14
CR0Pad2_R1Pad1 net_R0Pad2 net_R1Pad1 0.0
CR0Pad2_R1Pad2 net_R0Pad2 net_R1Pad2 0.0
CR1Pad1_G net_R1Pad1 0 4.476e-14
CR1Pad1_R1Pad2 net_R1Pad1 net_R1Pad2 0.0
CR1Pad2_G net_R1Pad2 0 2.961e-14
LQ0Pad1_Q0Pad2 net_Q0Pad1 net_Q0Pad2 1.24283629289458e-8
LQ1Pad1_Q1Pad2 net_Q1Pad1 net_Q1Pad2 1.25642765193031e-8
TR0Pad1_R0Pad2 net_R0Pad1 0 net_R0Pad2 0 Z0=50 TD=8.041666666666666e-11
TR1Pad1_R1Pad2 net_R1Pad1 0 net_R1Pad2 0 Z0=50 TD=7.875e-11
TFL_F0 Port1 0 net_F0 0 Z0=50 TD=3.666027291800768e-11
TF0_F1 net_F0 0 net_F1 0 Z0=50 TD=2.137499999957219e-11
TF1_FR net_F1 0 Port2 0 Z0=50 TD=3.6485245488713825e-11
RPort1 Port1 0 PORTNUM=1 RZ=50
.PORT Port1 0 1 RPort1
RPort2 Port2 0 PORTNUM=2 RZ=50
.PORT Port2 0 2 RPort2

.LNA
+ LIN 200 4000000000.0 7000000000.0
+ FLAG='LNA'

.end
reports:
  S Parameter Table 1: S(2,1) vs F on LNA : LNA
